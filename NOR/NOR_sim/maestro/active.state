ADE simulation setup
Test rafsun28_NOR_sim_1: rafsun28/NOR_sim/schematic, simulator spectre
  Models: /home/cadence/tech/gpdk045_v_6_0/gpdk045/../models/spectre/gpdk045.scs[mc]
  Temperature: 27
  Analysis tran: stop=100n
  Signals: /Vout, /Va, /Vb
Run mode: Single Run, Sweeps and Corners
