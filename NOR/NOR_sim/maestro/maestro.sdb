ADE simulation setup
Run mode: Single Run, Sweeps and Corners
Tests:
  rafsun28_NOR_sim_1: rafsun28/NOR_sim/schematic, simulator spectre
    Outputs: /Vout; /Va; /Vb
